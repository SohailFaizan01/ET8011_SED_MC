stage_1_2_bias
I4 1 2 I value={-ID2_P} noise=0 dc=0 dcvar=0
V1 3 1 V value=0 noise=0 dc=0 dcvar=0
V5 4 0 V value={VGS1C_N} noise=0 dc=0 dcvar=0
V6 5 0 V value={VDS1T_N} noise=0 dc=0 dcvar=0
V7 6 0 V value={VDS1_N} noise=0 dc=0 dcvar=0
V8 7 0 V value={VDS1C_N} noise=0 dc=0 dcvar=0
V10 3 0 V value={VDD} noise=0 dc=0 dcvar=0
V11 8 0 V value={VGS1_N} noise=0 dc=0 dcvar=0
X1 6 8 5 0 CMOS18N W={W1_N} L={L1_N} ID={ID1_N}
X4 0 7 2 2 CMOS18P W={W2_P} L={L2_P} ID={ID2_P}
X5 6 8 5 0 CMOS18N W={W1_N} L={L1_N} ID={ID1_N}
X7 7 4 6 0 CMOS18N W={W1C_N} L={L1C_N} ID={ID1_N}
X8 7 4 6 0 CMOS18N W={W1C_N} L={L1C_N} ID={ID1_N}
.end
